# Ansys Electronics Desktop project, version 2024.2
materials:
  vacuum: permittivity=1
  FR4_epoxy: permittivity=4.4 dielectric_loss_tangent=0.02

design PatchArray_HFSS (HFSS, HFSS Modal Network, model units mm)
variables:
  f0 = 2.4GHz
  h = 1.57mm
  Wpatch = 38.009975mm
  Lpatch = 29.432371mm
  d = 62.456762mm
  sx = 156.14191mm
  sy = 156.14191mm
  Amp_P1 = 0.25W
  Phi_P1 = 0deg
  Amp_P2 = 0.25W
  Phi_P2 = 0deg
  Amp_P3 = 0.25W
  Phi_P3 = 0deg
  Amp_P4 = 0.25W
  Phi_P4 = 0deg
geometry:
  GND = rectangle(corner=(-78.070953mm, -78.070953mm, 0mm), x_size=156.14191mm, y_size=156.14191mm)
  SUBSTRATE [FR4_epoxy] = box(corner=(-78.070953mm, -78.070953mm, 0mm), size=(156.14191mm, 156.14191mm, 1.57mm))
  PATCH_1_1 = rectangle(corner=(-50.233369mm, -45.944567mm, 1.57mm), x_size=38.009975mm, y_size=29.432371mm)
  PATCH_1_1_ObjectFromEdge1 = object_from(PATCH_1_1.edge(at (-50.2334, -31.2284, 1.57)))
  PATCH_1_1_ObjectFromEdge2 = object_from(PATCH_1_1.edge(at (-50.2334, -31.2284, 1.57)))
  PATCH_1_1_ObjectFromEdge2.move(0mm, 0mm, -1.57mm)
  PATCH_1_1_ObjectFromEdge1.connect(PATCH_1_1_ObjectFromEdge2)
  PATCH_2_1 = rectangle(corner=(12.223394mm, -45.944567mm, 1.57mm), x_size=38.009975mm, y_size=29.432371mm)
  PATCH_2_1_ObjectFromEdge1 = object_from(PATCH_2_1.edge(at (12.2234, -31.2284, 1.57)))
  PATCH_2_1_ObjectFromEdge2 = object_from(PATCH_2_1.edge(at (12.2234, -31.2284, 1.57)))
  PATCH_2_1_ObjectFromEdge2.move(0mm, 0mm, -1.57mm)
  PATCH_2_1_ObjectFromEdge1.connect(PATCH_2_1_ObjectFromEdge2)
  PATCH_1_2 = rectangle(corner=(-50.233369mm, 16.512195mm, 1.57mm), x_size=38.009975mm, y_size=29.432371mm)
  PATCH_1_2_ObjectFromEdge1 = object_from(PATCH_1_2.edge(at (-50.2334, 31.2284, 1.57)))
  PATCH_1_2_ObjectFromEdge2 = object_from(PATCH_1_2.edge(at (-50.2334, 31.2284, 1.57)))
  PATCH_1_2_ObjectFromEdge2.move(0mm, 0mm, -1.57mm)
  PATCH_1_2_ObjectFromEdge1.connect(PATCH_1_2_ObjectFromEdge2)
  PATCH_2_2 = rectangle(corner=(12.223394mm, 16.512195mm, 1.57mm), x_size=38.009975mm, y_size=29.432371mm)
  PATCH_2_2_ObjectFromEdge1 = object_from(PATCH_2_2.edge(at (12.2234, 31.2284, 1.57)))
  PATCH_2_2_ObjectFromEdge2 = object_from(PATCH_2_2.edge(at (12.2234, 31.2284, 1.57)))
  PATCH_2_2_ObjectFromEdge2.move(0mm, 0mm, -1.57mm)
  PATCH_2_2_ObjectFromEdge1.connect(PATCH_2_2_ObjectFromEdge2)
  RadiatingSurface [vacuum] = region(absolute_offset=41.666667mm on all sides)
boundaries and excitations:
  PerfE_E3MWZQ: Perfect E Objects=GND
  PerfE_U9WCYX: Perfect E Objects=PATCH_1_1
  PerfE_PKYNAV: Perfect E Objects=PATCH_2_1
  PerfE_O95XWW: Perfect E Objects=PATCH_1_2
  PerfE_SU0EM7: Perfect E Objects=PATCH_2_2
  Open1: Radiation Objects=RadiatingSurface
  P1: Lumped Port Objects=PATCH_1_1_ObjectFromEdge1 LumpedPortType=Modal Modes{Mode1{IntLine{(-50.233369, -31.228381, 1.57) -> (-50.233369, -31.228381, 0)} CharImp=Zpi RenormImp=50ohm}} Impedance=50ohm
  P2: Lumped Port Objects=PATCH_2_1_ObjectFromEdge1 LumpedPortType=Modal Modes{Mode1{IntLine{(12.223394, -31.228381, 1.57) -> (12.223394, -31.228381, 0)} CharImp=Zpi RenormImp=50ohm}} Impedance=50ohm
  P3: Lumped Port Objects=PATCH_1_2_ObjectFromEdge1 LumpedPortType=Modal Modes{Mode1{IntLine{(-50.233369, 31.228381, 1.57) -> (-50.233369, 31.228381, 0)} CharImp=Zpi RenormImp=50ohm}} Impedance=50ohm
  P4: Lumped Port Objects=PATCH_2_2_ObjectFromEdge1 LumpedPortType=Modal Modes{Mode1{IntLine{(12.223394, 31.228381, 1.57) -> (12.223394, 31.228381, 0)} CharImp=Zpi RenormImp=50ohm}} Impedance=50ohm
setups:
  Auto1: HfssDriven Frequency=5GHz MaxDeltaS=0.02 MaximumPasses=6 MinimumPasses=1 MinimumConvergedPasses=1 PercentRefinement=30 BasisOrder=1 PortAccuracy=2 DrivenSolverType="Direct Solver"
  Setup1: HfssDriven Frequency=2.4GHz MaxDeltaS=0.02 MaximumPasses=6 MinimumPasses=1 MinimumConvergedPasses=1 PercentRefinement=30 BasisOrder=1 PortAccuracy=2 DrivenSolverType="Direct Solver"
    sweep Sweep_10KXKH: 2.3GHz to 2.5GHz, 101 points; Type=Interpolating SaveFields InterpTolerance=0.5 InterpMaxSolns=250 InterpUsePortImped=false PassivityErrorTolerance=0.0001
source amplitudes:
  P1:1: 1W 0deg
  P2:1, P3:1, P4:1: 0W 0deg
radiation setups:
  3D: Infinite Sphere Theta=0deg..180deg step 2deg Phi=-180deg..180deg step 2deg
  Elevation: Infinite Sphere Theta=-180deg..180deg step 1deg Phi=0deg..90deg step 90deg
  Azimuth: Infinite Sphere Theta=90deg..90deg step 0deg Phi=-180deg..180deg step 1deg
